* DESK synthetic divider
R1 vin vout 10000
R2 vout 0 10000
VIN vin 0 DC 10
.control
set filetype=ascii
echo DESK_BEGIN op1
op
write op1.raw
echo DESK_END op1
echo DESK_DONE
quit
.endc
.end
